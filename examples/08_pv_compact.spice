* Terminal fit at 300 K; no charge/Rs/shunt model
.subckt photovoltaic p n params: illumination=1000 area_scale=1
Iphoto n p DC {1e-07*illumination/1000*area_scale}
Dpv p n photovoltaic_diode area={area_scale}
.model photovoltaic_diode D(IS=2e-16 N=2.6 TNOM=26.85 EG=0 XTI=0)
.ends photovoltaic
