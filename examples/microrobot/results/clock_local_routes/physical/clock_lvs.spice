* NGSPICE file created from microrobot_clock.ext - technology: sky130A

.subckt microrobot_clock clk vdd vss bias_n bias_p
X0 Xc3.C1 vss sky130_fd_pr__cap_mim_m3_1 l=2 w=2
X1 vss bias_n bias_p vss sky130_fd_pr__nfet_01v8 ad=0.145 pd=1.58 as=0.145 ps=1.58 w=0.5 l=8
X2 Xc4.C1 vss sky130_fd_pr__cap_mim_m3_1 l=2 w=2
X3 X2_Xps.D Xc1.C1 Xc2.C1 vdd sky130_fd_pr__pfet_01v8 ad=0.29 pd=2.58 as=0.29 ps=2.58 w=1 l=0.5
X4 vss bias_n X2_Xns.D vss sky130_fd_pr__nfet_01v8 ad=0.145 pd=1.58 as=0.145 ps=1.58 w=0.5 l=8
X5 vdd bias_p X1_Xps.D vdd sky130_fd_pr__pfet_01v8 ad=0.29 pd=2.58 as=0.29 ps=2.58 w=1 l=8
X6 X1_Xns.D X1_Xpi.G Xc1.C1 vss sky130_fd_pr__nfet_01v8 ad=0.145 pd=1.58 as=0.145 ps=1.58 w=0.5 l=0.5
X7 vdd bias_p bias_p vdd sky130_fd_pr__pfet_01v8 ad=0.29 pd=2.58 as=0.29 ps=2.58 w=1 l=8
X8 X5_Xps.D Xc4.C1 X1_Xpi.G vdd sky130_fd_pr__pfet_01v8 ad=0.29 pd=2.58 as=0.29 ps=2.58 w=1 l=0.5
X9 vdd X1_Xpi.G Xbp1.D vdd sky130_fd_pr__pfet_01v8 ad=0.29 pd=2.58 as=0.29 ps=2.58 w=1 l=8
X10 vdd bias_p X4_Xps.D vdd sky130_fd_pr__pfet_01v8 ad=0.29 pd=2.58 as=0.29 ps=2.58 w=1 l=8
X11 X4_Xns.D Xc3.C1 Xc4.C1 vss sky130_fd_pr__nfet_01v8 ad=0.145 pd=1.58 as=0.145 ps=1.58 w=0.5 l=0.5
X12 vss bias_n bias_n vss sky130_fd_pr__nfet_01v8 ad=0.145 pd=1.58 as=0.145 ps=1.58 w=0.5 l=8
X13 Xbias.Xb2.D vdd vdd vss sky130_fd_pr__nfet_01v8 ad=0.145 pd=1.58 as=0.145 ps=1.58 w=0.5 l=8
X14 vdd Xbp1.D clk vdd sky130_fd_pr__pfet_01v8 ad=0.29 pd=2.58 as=0.29 ps=2.58 w=1 l=1
X15 vss bias_n X5_Xns.D vss sky130_fd_pr__nfet_01v8 ad=0.145 pd=1.58 as=0.145 ps=1.58 w=0.5 l=8
X16 X3_Xps.D Xc2.C1 Xc3.C1 vdd sky130_fd_pr__pfet_01v8 ad=0.29 pd=2.58 as=0.29 ps=2.58 w=1 l=0.5
X17 Xc1.C1 vss sky130_fd_pr__cap_mim_m3_1 l=2 w=2
X18 vdd bias_p X2_Xps.D vdd sky130_fd_pr__pfet_01v8 ad=0.29 pd=2.58 as=0.29 ps=2.58 w=1 l=8
X19 bias_n vss sky130_fd_pr__cap_mim_m3_1 l=7 w=7
X20 Xc2.C1 vss sky130_fd_pr__cap_mim_m3_1 l=2 w=2
X21 vss bias_n X3_Xns.D vss sky130_fd_pr__nfet_01v8 ad=0.145 pd=1.58 as=0.145 ps=1.58 w=0.5 l=8
X22 X1_Xpi.G vss sky130_fd_pr__cap_mim_m3_1 l=2.5 w=2
X23 bias_p vss sky130_fd_pr__cap_mim_m3_1 l=7 w=7
X24 X2_Xns.D Xc1.C1 Xc2.C1 vss sky130_fd_pr__nfet_01v8 ad=0.145 pd=1.58 as=0.145 ps=1.58 w=0.5 l=0.5
X25 vdd bias_p X5_Xps.D vdd sky130_fd_pr__pfet_01v8 ad=0.29 pd=2.58 as=0.29 ps=2.58 w=1 l=8
X26 X5_Xns.D Xc4.C1 X1_Xpi.G vss sky130_fd_pr__nfet_01v8 ad=0.145 pd=1.58 as=0.145 ps=1.58 w=0.5 l=0.5
X27 vss X1_Xpi.G Xbp1.D vss sky130_fd_pr__nfet_01v8 ad=0.145 pd=1.58 as=0.145 ps=1.58 w=0.5 l=8
X28 bias_n Xbias.Xb2.D Xbias.Xb2.D vss sky130_fd_pr__nfet_01v8 ad=0.145 pd=1.58 as=0.145 ps=1.58 w=0.5 l=8
X29 X1_Xps.D X1_Xpi.G Xc1.C1 vdd sky130_fd_pr__pfet_01v8 ad=0.29 pd=2.58 as=0.29 ps=2.58 w=1 l=0.5
X30 vss bias_n X1_Xns.D vss sky130_fd_pr__nfet_01v8 ad=0.145 pd=1.58 as=0.145 ps=1.58 w=0.5 l=8
X31 vss Xbp1.D clk vss sky130_fd_pr__nfet_01v8 ad=0.145 pd=1.58 as=0.145 ps=1.58 w=0.5 l=1
X32 X4_Xps.D Xc3.C1 Xc4.C1 vdd sky130_fd_pr__pfet_01v8 ad=0.29 pd=2.58 as=0.29 ps=2.58 w=1 l=0.5
X33 vss bias_n X4_Xns.D vss sky130_fd_pr__nfet_01v8 ad=0.145 pd=1.58 as=0.145 ps=1.58 w=0.5 l=8
X34 vdd bias_p X3_Xps.D vdd sky130_fd_pr__pfet_01v8 ad=0.29 pd=2.58 as=0.29 ps=2.58 w=1 l=8
X35 X3_Xns.D Xc2.C1 Xc3.C1 vss sky130_fd_pr__nfet_01v8 ad=0.145 pd=1.58 as=0.145 ps=1.58 w=0.5 l=0.5
.ends
