* Our low-power clock candidate; three scaled S2E-fit cells, optical ramp, chosen storage capacitor
.lib "/usr/local/share/pdk/sky130A/libs.tech/ngspice/sky130.lib.spice" sf
.temp 26.85
* Functional open-PDK candidate, not a reproduction of Reynolds' PTAT clock.
* Diode-stack bias is supply/temperature dependent. No compensated reference.
* All W/L in um under the installed SKY130 model scale.
.subckt microrobot_clock clk vdd vss bias_n bias_p
* A passive diode-connected stack has a nonzero DC path at illumination.
Vbias vdd ref_vdd 0
Xb1 bias_n bias_n vss vss sky130_fd_pr__nfet_01v8 w=0.5 l=8
Xb2 b2 b2 bias_n vss sky130_fd_pr__nfet_01v8 w=0.5 l=8
Xb3 ref_vdd ref_vdd b2 vss sky130_fd_pr__nfet_01v8 w=0.5 l=8
Xmirror bias_p bias_n vss vss sky130_fd_pr__nfet_01v8 w=0.5 l=8
Xpdiode bias_p bias_p ref_vdd vdd sky130_fd_pr__pfet_01v8 w=1 l=8
Xcbiasp bias_p vss sky130_fd_pr__cap_mim_m3_1 w=7 l=7
Xcbiasn bias_n vss sky130_fd_pr__cap_mim_m3_1 w=7 l=7
X1 raw a vdd vss bias_p bias_n micro_starved_inv
X2 a b vdd vss bias_p bias_n micro_starved_inv
X3 b c vdd vss bias_p bias_n micro_starved_inv
X4 c d vdd vss bias_p bias_n micro_starved_inv
X5 d raw vdd vss bias_p bias_n micro_starved_inv
Xc1 a vss sky130_fd_pr__cap_mim_m3_1 w=2 l=2
Xc2 b vss sky130_fd_pr__cap_mim_m3_1 w=2 l=2
Xc3 c vss sky130_fd_pr__cap_mim_m3_1 w=2 l=2
Xc4 d vss sky130_fd_pr__cap_mim_m3_1 w=2 l=2
* Deliberate timing-capacitor asymmetry for nominal startup.
Xc5 raw vss sky130_fd_pr__cap_mim_m3_1 w=2 l=2.5
* Long-channel receiver first, then a smaller faster receiver. Their supply
* current is included; a slow raw ring must not drive digital gates for free.
Xbp1 buffered raw vdd vdd sky130_fd_pr__pfet_01v8 w=1 l=8
Xbn1 buffered raw vss vss sky130_fd_pr__nfet_01v8 w=0.5 l=8
Xbp2 clk buffered vdd vdd sky130_fd_pr__pfet_01v8 w=1 l=1
Xbn2 clk buffered vss vss sky130_fd_pr__nfet_01v8 w=0.5 l=1
.ends microrobot_clock

.subckt micro_starved_inv a y vdd vss bp bn
Xps ps bp vdd vdd sky130_fd_pr__pfet_01v8 w=1 l=8
Xpi y a ps vdd sky130_fd_pr__pfet_01v8 w=1 l=0.5
Xni y a ns vss sky130_fd_pr__nfet_01v8 w=0.5 l=0.5
Xns ns bn vss vss sky130_fd_pr__nfet_01v8 w=0.5 l=8
.ends micro_starved_inv

Vlight illumination 0 PWL(0 0 1u 0 0.000101 1000)
.model fitted_pv D(IS=2.9405522317e-17 N=1.14470885396 TNOM=26.85 EG=0 XTI=0)
Bph1 0 pv1 I={4.0350658074e-08*v(illumination)/1000}
Bph2 pv1 pv2 I={4.0350658074e-08*v(illumination)/1000}
Bph3 pv2 supply I={4.0350658074e-08*v(illumination)/1000}
Dp1 pv1 0 fitted_pv
Dp2 pv2 pv1 fitted_pv
Dp3 supply pv2 fitted_pv
Cstore supply 0 2e-12
Vsense supply vdd 0
Xclock clk vdd 0 bn bp microrobot_clock
Vlogic supply digital_supply 0
.include "receiver_cells.spice"
Xff clk feedback 0 0 digital_supply digital_supply div2 sky130_fd_sc_hd__dfxtp_1
Xfeedback div2 0 0 digital_supply digital_supply feedback sky130_fd_sc_hd__inv_1
Coutput clk 0 2e-15
.options method=gear maxord=2 reltol=1e-4 abstol=1e-15
.control
set wr_vecnames
set wr_singlescale
tran 5e-08 0.004 0 5e-08
wrdata clock.dat v(vdd) v(clk) v(bn) v(bp) i(Vsense) i(Vlogic) v(div2) i(v.xclock.vbias)
quit
.endc
.end
