* Native DC verification of bounded DD PWL terminal sources
Vcell cell 0 0
Espan2 span2 0 cell 0 2
Bn2f0 0 sinkn2f0 I={1080*(pwl(v(span2)/2,0,-0,0.025000000000000001,-5.1031397811909158e-18,0.050000000000000003,-1.6900886162475216e-17,0.075000000000000011,-4.5544351773723475e-17,0.10000000000000001,-1.1706894591230417e-16,0.125,-2.9905618250101119e-16,0.15000000000000002,-7.6734017987466285e-16,0.17500000000000002,-1.9811143841814144e-15,0.20000000000000001,-5.1413199188098177e-15,0.22500000000000001,-1.339248219197384e-14,0.25,-3.4973150376715681e-14,0.27500000000000002,-9.147661302376481e-14,0.30000000000000004,-2.395109599907038e-13,0.32500000000000001,-6.2749260021912781e-13,0.35000000000000003,-1.6445520176143913e-12,0.375,-4.3109100739383552e-12,0.40000000000000002,-1.1301168443375023e-11,0.42500000000000004,-2.9626190973570329e-11,0.45000000000000001,-7.7660228884154431e-11,0.47500000000000003,-2.0354713172770298e-10,0.5,-5.3338403005281748e-10,0.52500000000000002,-1.3972186876001106e-09,0.55000000000000004,-3.6577646074621611e-09,0.57500000000000007,-9.5634616726067801e-09,0.60000000000000009,-2.4934425046235657e-08,0.625,-6.4594783222970078e-08,0.65000000000000002,-1.6493085582319065e-07,0.67500000000000004,-4.0868130472980025e-07,0.70000000000000007,-9.6116247988053517e-07)+(0)*pwl(v(span2)/2,0,1.3549730611554419e-10,0.025000000000000001,1.3530083740007976e-10,0.050000000000000003,1.3510067269867956e-10,0.075000000000000011,1.3489660604312171e-10,0.10000000000000001,1.3468840825548359e-10,0.125,1.3447582330367215e-10,0.15000000000000002,1.3425856378492235e-10,0.17500000000000002,1.3403630585283119e-10,0.20000000000000001,1.3380868292412021e-10,0.22500000000000001,1.3357527812743415e-10,0.25,1.3333561450239847e-10,0.27500000000000002,1.3308914246389753e-10,0.30000000000000004,1.3283522208410721e-10,0.32500000000000001,1.3257309692922724e-10,0.35000000000000003,1.3230185109608407e-10,0.375,1.3202033046964549e-10,0.40000000000000002,1.3172698169543378e-10,0.42500000000000004,1.3141949265403456e-10,0.45000000000000001,1.310939383324102e-10,0.47500000000000003,1.3074267257959103e-10,0.5,1.30349005494306e-10,0.52500000000000002,1.2987360928719349e-10,0.55000000000000004,1.292197028599079e-10,0.57500000000000007,1.2814464613602281e-10,0.60000000000000009,1.2604226983527328e-10,0.625,1.2145042997884143e-10,0.65000000000000002,1.111646447815761e-10,0.67500000000000004,8.9506181583909814e-11,0.70000000000000007,4.9789836233574323e-11))}
Vn2f0 sinkn2f0 0 0
Bn2f5 0 sinkn2f5 I={1080*(pwl(v(span2)/2,0,-0,0.025000000000000001,-5.1031397811909158e-18,0.050000000000000003,-1.6900886162475216e-17,0.075000000000000011,-4.5544351773723475e-17,0.10000000000000001,-1.1706894591230417e-16,0.125,-2.9905618250101119e-16,0.15000000000000002,-7.6734017987466285e-16,0.17500000000000002,-1.9811143841814144e-15,0.20000000000000001,-5.1413199188098177e-15,0.22500000000000001,-1.339248219197384e-14,0.25,-3.4973150376715681e-14,0.27500000000000002,-9.147661302376481e-14,0.30000000000000004,-2.395109599907038e-13,0.32500000000000001,-6.2749260021912781e-13,0.35000000000000003,-1.6445520176143913e-12,0.375,-4.3109100739383552e-12,0.40000000000000002,-1.1301168443375023e-11,0.42500000000000004,-2.9626190973570329e-11,0.45000000000000001,-7.7660228884154431e-11,0.47500000000000003,-2.0354713172770298e-10,0.5,-5.3338403005281748e-10,0.52500000000000002,-1.3972186876001106e-09,0.55000000000000004,-3.6577646074621611e-09,0.57500000000000007,-9.5634616726067801e-09,0.60000000000000009,-2.4934425046235657e-08,0.625,-6.4594783222970078e-08,0.65000000000000002,-1.6493085582319065e-07,0.67500000000000004,-4.0868130472980025e-07,0.70000000000000007,-9.6116247988053517e-07)+(0.5)*pwl(v(span2)/2,0,1.3549730611554419e-10,0.025000000000000001,1.3530083740007976e-10,0.050000000000000003,1.3510067269867956e-10,0.075000000000000011,1.3489660604312171e-10,0.10000000000000001,1.3468840825548359e-10,0.125,1.3447582330367215e-10,0.15000000000000002,1.3425856378492235e-10,0.17500000000000002,1.3403630585283119e-10,0.20000000000000001,1.3380868292412021e-10,0.22500000000000001,1.3357527812743415e-10,0.25,1.3333561450239847e-10,0.27500000000000002,1.3308914246389753e-10,0.30000000000000004,1.3283522208410721e-10,0.32500000000000001,1.3257309692922724e-10,0.35000000000000003,1.3230185109608407e-10,0.375,1.3202033046964549e-10,0.40000000000000002,1.3172698169543378e-10,0.42500000000000004,1.3141949265403456e-10,0.45000000000000001,1.310939383324102e-10,0.47500000000000003,1.3074267257959103e-10,0.5,1.30349005494306e-10,0.52500000000000002,1.2987360928719349e-10,0.55000000000000004,1.292197028599079e-10,0.57500000000000007,1.2814464613602281e-10,0.60000000000000009,1.2604226983527328e-10,0.625,1.2145042997884143e-10,0.65000000000000002,1.111646447815761e-10,0.67500000000000004,8.9506181583909814e-11,0.70000000000000007,4.9789836233574323e-11))}
Vn2f5 sinkn2f5 0 0
Bn2f10 0 sinkn2f10 I={1080*(pwl(v(span2)/2,0,-0,0.025000000000000001,-5.1031397811909158e-18,0.050000000000000003,-1.6900886162475216e-17,0.075000000000000011,-4.5544351773723475e-17,0.10000000000000001,-1.1706894591230417e-16,0.125,-2.9905618250101119e-16,0.15000000000000002,-7.6734017987466285e-16,0.17500000000000002,-1.9811143841814144e-15,0.20000000000000001,-5.1413199188098177e-15,0.22500000000000001,-1.339248219197384e-14,0.25,-3.4973150376715681e-14,0.27500000000000002,-9.147661302376481e-14,0.30000000000000004,-2.395109599907038e-13,0.32500000000000001,-6.2749260021912781e-13,0.35000000000000003,-1.6445520176143913e-12,0.375,-4.3109100739383552e-12,0.40000000000000002,-1.1301168443375023e-11,0.42500000000000004,-2.9626190973570329e-11,0.45000000000000001,-7.7660228884154431e-11,0.47500000000000003,-2.0354713172770298e-10,0.5,-5.3338403005281748e-10,0.52500000000000002,-1.3972186876001106e-09,0.55000000000000004,-3.6577646074621611e-09,0.57500000000000007,-9.5634616726067801e-09,0.60000000000000009,-2.4934425046235657e-08,0.625,-6.4594783222970078e-08,0.65000000000000002,-1.6493085582319065e-07,0.67500000000000004,-4.0868130472980025e-07,0.70000000000000007,-9.6116247988053517e-07)+(1)*pwl(v(span2)/2,0,1.3549730611554419e-10,0.025000000000000001,1.3530083740007976e-10,0.050000000000000003,1.3510067269867956e-10,0.075000000000000011,1.3489660604312171e-10,0.10000000000000001,1.3468840825548359e-10,0.125,1.3447582330367215e-10,0.15000000000000002,1.3425856378492235e-10,0.17500000000000002,1.3403630585283119e-10,0.20000000000000001,1.3380868292412021e-10,0.22500000000000001,1.3357527812743415e-10,0.25,1.3333561450239847e-10,0.27500000000000002,1.3308914246389753e-10,0.30000000000000004,1.3283522208410721e-10,0.32500000000000001,1.3257309692922724e-10,0.35000000000000003,1.3230185109608407e-10,0.375,1.3202033046964549e-10,0.40000000000000002,1.3172698169543378e-10,0.42500000000000004,1.3141949265403456e-10,0.45000000000000001,1.310939383324102e-10,0.47500000000000003,1.3074267257959103e-10,0.5,1.30349005494306e-10,0.52500000000000002,1.2987360928719349e-10,0.55000000000000004,1.292197028599079e-10,0.57500000000000007,1.2814464613602281e-10,0.60000000000000009,1.2604226983527328e-10,0.625,1.2145042997884143e-10,0.65000000000000002,1.111646447815761e-10,0.67500000000000004,8.9506181583909814e-11,0.70000000000000007,4.9789836233574323e-11))}
Vn2f10 sinkn2f10 0 0
Espan4 span4 0 cell 0 4
Bn4f0 0 sinkn4f0 I={1080*(pwl(v(span4)/4,0,-0,0.025000000000000001,-5.1031397811909158e-18,0.050000000000000003,-1.6900886162475216e-17,0.075000000000000011,-4.5544351773723475e-17,0.10000000000000001,-1.1706894591230417e-16,0.125,-2.9905618250101119e-16,0.15000000000000002,-7.6734017987466285e-16,0.17500000000000002,-1.9811143841814144e-15,0.20000000000000001,-5.1413199188098177e-15,0.22500000000000001,-1.339248219197384e-14,0.25,-3.4973150376715681e-14,0.27500000000000002,-9.147661302376481e-14,0.30000000000000004,-2.395109599907038e-13,0.32500000000000001,-6.2749260021912781e-13,0.35000000000000003,-1.6445520176143913e-12,0.375,-4.3109100739383552e-12,0.40000000000000002,-1.1301168443375023e-11,0.42500000000000004,-2.9626190973570329e-11,0.45000000000000001,-7.7660228884154431e-11,0.47500000000000003,-2.0354713172770298e-10,0.5,-5.3338403005281748e-10,0.52500000000000002,-1.3972186876001106e-09,0.55000000000000004,-3.6577646074621611e-09,0.57500000000000007,-9.5634616726067801e-09,0.60000000000000009,-2.4934425046235657e-08,0.625,-6.4594783222970078e-08,0.65000000000000002,-1.6493085582319065e-07,0.67500000000000004,-4.0868130472980025e-07,0.70000000000000007,-9.6116247988053517e-07)+(0)*pwl(v(span4)/4,0,1.3549730611554419e-10,0.025000000000000001,1.3530083740007976e-10,0.050000000000000003,1.3510067269867956e-10,0.075000000000000011,1.3489660604312171e-10,0.10000000000000001,1.3468840825548359e-10,0.125,1.3447582330367215e-10,0.15000000000000002,1.3425856378492235e-10,0.17500000000000002,1.3403630585283119e-10,0.20000000000000001,1.3380868292412021e-10,0.22500000000000001,1.3357527812743415e-10,0.25,1.3333561450239847e-10,0.27500000000000002,1.3308914246389753e-10,0.30000000000000004,1.3283522208410721e-10,0.32500000000000001,1.3257309692922724e-10,0.35000000000000003,1.3230185109608407e-10,0.375,1.3202033046964549e-10,0.40000000000000002,1.3172698169543378e-10,0.42500000000000004,1.3141949265403456e-10,0.45000000000000001,1.310939383324102e-10,0.47500000000000003,1.3074267257959103e-10,0.5,1.30349005494306e-10,0.52500000000000002,1.2987360928719349e-10,0.55000000000000004,1.292197028599079e-10,0.57500000000000007,1.2814464613602281e-10,0.60000000000000009,1.2604226983527328e-10,0.625,1.2145042997884143e-10,0.65000000000000002,1.111646447815761e-10,0.67500000000000004,8.9506181583909814e-11,0.70000000000000007,4.9789836233574323e-11))}
Vn4f0 sinkn4f0 0 0
Bn4f5 0 sinkn4f5 I={1080*(pwl(v(span4)/4,0,-0,0.025000000000000001,-5.1031397811909158e-18,0.050000000000000003,-1.6900886162475216e-17,0.075000000000000011,-4.5544351773723475e-17,0.10000000000000001,-1.1706894591230417e-16,0.125,-2.9905618250101119e-16,0.15000000000000002,-7.6734017987466285e-16,0.17500000000000002,-1.9811143841814144e-15,0.20000000000000001,-5.1413199188098177e-15,0.22500000000000001,-1.339248219197384e-14,0.25,-3.4973150376715681e-14,0.27500000000000002,-9.147661302376481e-14,0.30000000000000004,-2.395109599907038e-13,0.32500000000000001,-6.2749260021912781e-13,0.35000000000000003,-1.6445520176143913e-12,0.375,-4.3109100739383552e-12,0.40000000000000002,-1.1301168443375023e-11,0.42500000000000004,-2.9626190973570329e-11,0.45000000000000001,-7.7660228884154431e-11,0.47500000000000003,-2.0354713172770298e-10,0.5,-5.3338403005281748e-10,0.52500000000000002,-1.3972186876001106e-09,0.55000000000000004,-3.6577646074621611e-09,0.57500000000000007,-9.5634616726067801e-09,0.60000000000000009,-2.4934425046235657e-08,0.625,-6.4594783222970078e-08,0.65000000000000002,-1.6493085582319065e-07,0.67500000000000004,-4.0868130472980025e-07,0.70000000000000007,-9.6116247988053517e-07)+(0.5)*pwl(v(span4)/4,0,1.3549730611554419e-10,0.025000000000000001,1.3530083740007976e-10,0.050000000000000003,1.3510067269867956e-10,0.075000000000000011,1.3489660604312171e-10,0.10000000000000001,1.3468840825548359e-10,0.125,1.3447582330367215e-10,0.15000000000000002,1.3425856378492235e-10,0.17500000000000002,1.3403630585283119e-10,0.20000000000000001,1.3380868292412021e-10,0.22500000000000001,1.3357527812743415e-10,0.25,1.3333561450239847e-10,0.27500000000000002,1.3308914246389753e-10,0.30000000000000004,1.3283522208410721e-10,0.32500000000000001,1.3257309692922724e-10,0.35000000000000003,1.3230185109608407e-10,0.375,1.3202033046964549e-10,0.40000000000000002,1.3172698169543378e-10,0.42500000000000004,1.3141949265403456e-10,0.45000000000000001,1.310939383324102e-10,0.47500000000000003,1.3074267257959103e-10,0.5,1.30349005494306e-10,0.52500000000000002,1.2987360928719349e-10,0.55000000000000004,1.292197028599079e-10,0.57500000000000007,1.2814464613602281e-10,0.60000000000000009,1.2604226983527328e-10,0.625,1.2145042997884143e-10,0.65000000000000002,1.111646447815761e-10,0.67500000000000004,8.9506181583909814e-11,0.70000000000000007,4.9789836233574323e-11))}
Vn4f5 sinkn4f5 0 0
Bn4f10 0 sinkn4f10 I={1080*(pwl(v(span4)/4,0,-0,0.025000000000000001,-5.1031397811909158e-18,0.050000000000000003,-1.6900886162475216e-17,0.075000000000000011,-4.5544351773723475e-17,0.10000000000000001,-1.1706894591230417e-16,0.125,-2.9905618250101119e-16,0.15000000000000002,-7.6734017987466285e-16,0.17500000000000002,-1.9811143841814144e-15,0.20000000000000001,-5.1413199188098177e-15,0.22500000000000001,-1.339248219197384e-14,0.25,-3.4973150376715681e-14,0.27500000000000002,-9.147661302376481e-14,0.30000000000000004,-2.395109599907038e-13,0.32500000000000001,-6.2749260021912781e-13,0.35000000000000003,-1.6445520176143913e-12,0.375,-4.3109100739383552e-12,0.40000000000000002,-1.1301168443375023e-11,0.42500000000000004,-2.9626190973570329e-11,0.45000000000000001,-7.7660228884154431e-11,0.47500000000000003,-2.0354713172770298e-10,0.5,-5.3338403005281748e-10,0.52500000000000002,-1.3972186876001106e-09,0.55000000000000004,-3.6577646074621611e-09,0.57500000000000007,-9.5634616726067801e-09,0.60000000000000009,-2.4934425046235657e-08,0.625,-6.4594783222970078e-08,0.65000000000000002,-1.6493085582319065e-07,0.67500000000000004,-4.0868130472980025e-07,0.70000000000000007,-9.6116247988053517e-07)+(1)*pwl(v(span4)/4,0,1.3549730611554419e-10,0.025000000000000001,1.3530083740007976e-10,0.050000000000000003,1.3510067269867956e-10,0.075000000000000011,1.3489660604312171e-10,0.10000000000000001,1.3468840825548359e-10,0.125,1.3447582330367215e-10,0.15000000000000002,1.3425856378492235e-10,0.17500000000000002,1.3403630585283119e-10,0.20000000000000001,1.3380868292412021e-10,0.22500000000000001,1.3357527812743415e-10,0.25,1.3333561450239847e-10,0.27500000000000002,1.3308914246389753e-10,0.30000000000000004,1.3283522208410721e-10,0.32500000000000001,1.3257309692922724e-10,0.35000000000000003,1.3230185109608407e-10,0.375,1.3202033046964549e-10,0.40000000000000002,1.3172698169543378e-10,0.42500000000000004,1.3141949265403456e-10,0.45000000000000001,1.310939383324102e-10,0.47500000000000003,1.3074267257959103e-10,0.5,1.30349005494306e-10,0.52500000000000002,1.2987360928719349e-10,0.55000000000000004,1.292197028599079e-10,0.57500000000000007,1.2814464613602281e-10,0.60000000000000009,1.2604226983527328e-10,0.625,1.2145042997884143e-10,0.65000000000000002,1.111646447815761e-10,0.67500000000000004,8.9506181583909814e-11,0.70000000000000007,4.9789836233574323e-11))}
Vn4f10 sinkn4f10 0 0
.control
set wr_vecnames
set wr_singlescale
set numdgt=17
dc Vcell 0 .7 .0125
wrdata source.dat i(Vn2f0) i(Vn2f5) i(Vn2f10) i(Vn4f0) i(Vn4f5) i(Vn4f10)
quit
.endc
.end
